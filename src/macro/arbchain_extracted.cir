* Extracted by KLayout with SKY130 LVS runset on : 31/08/2026 14:14

.SUBCKT arbchain
X$1 VGND \$4 launch launch ch[0] VPWR \$I125 VGND sky130_fd_sc_hd__mux2_1
X$2 VGND \$6 launch launch ch[0] VPWR VPWR VGND sky130_fd_sc_hd__mux2_1
X$3 VGND \$12 \$6 \$4 ch[1] VPWR \$I140 VGND sky130_fd_sc_hd__mux2_1
X$4 VGND \$13 \$4 \$6 ch[1] VPWR VPWR VGND sky130_fd_sc_hd__mux2_1
X$5 VGND arb_rst_n \$121 \$119 \$111 VPWR \$118 VGND sky130_fd_sc_hd__dlrtp_1
X$6 VGND \$20 \$12 \$13 ch[2] VPWR VPWR VGND sky130_fd_sc_hd__mux2_1
X$7 VGND \$27 \$19 \$20 ch[3] VPWR VPWR VGND sky130_fd_sc_hd__mux2_1
X$8 VGND \$34 \$26 \$27 ch[4] VPWR VPWR VGND sky130_fd_sc_hd__mux2_1
X$9 VGND \$41 \$33 \$34 ch[5] VPWR VPWR VGND sky130_fd_sc_hd__mux2_1
X$10 VGND \$48 \$40 \$41 ch[6] VPWR VPWR VGND sky130_fd_sc_hd__mux2_1
X$11 VGND \$55 \$47 \$48 ch[7] VPWR VPWR VGND sky130_fd_sc_hd__mux2_1
X$12 VGND \$62 \$54 \$55 ch[8] VPWR VPWR VGND sky130_fd_sc_hd__mux2_1
X$13 VGND \$69 \$61 \$62 ch[9] VPWR VPWR VGND sky130_fd_sc_hd__mux2_1
X$14 VGND \$76 \$68 \$69 ch[10] VPWR VPWR VGND sky130_fd_sc_hd__mux2_1
X$15 VGND \$83 \$75 \$76 ch[11] VPWR VPWR VGND sky130_fd_sc_hd__mux2_1
X$16 VGND \$111 \$103 \$104 ch[15] VPWR VPWR VGND sky130_fd_sc_hd__mux2_1
X$17 VGND \$90 \$82 \$83 ch[12] VPWR VPWR VGND sky130_fd_sc_hd__mux2_1
X$18 VGND \$104 \$96 \$97 ch[14] VPWR VPWR VGND sky130_fd_sc_hd__mux2_1
X$19 VGND \$97 \$89 \$90 ch[13] VPWR VPWR VGND sky130_fd_sc_hd__mux2_1
X$20 VGND \$19 \$13 \$12 ch[2] VPWR \$I139 VGND sky130_fd_sc_hd__mux2_1
X$21 VGND \$110 \$104 \$103 ch[15] VPWR \$I138 VGND sky130_fd_sc_hd__mux2_1
X$22 VGND \$26 \$20 \$19 ch[3] VPWR \$I137 VGND sky130_fd_sc_hd__mux2_1
X$23 VGND \$33 \$27 \$26 ch[4] VPWR \$I136 VGND sky130_fd_sc_hd__mux2_1
X$24 VGND \$103 \$97 \$96 ch[14] VPWR \$I135 VGND sky130_fd_sc_hd__mux2_1
X$25 VGND \$40 \$34 \$33 ch[5] VPWR \$I134 VGND sky130_fd_sc_hd__mux2_1
X$26 VGND \$47 \$41 \$40 ch[6] VPWR \$I133 VGND sky130_fd_sc_hd__mux2_1
X$27 VGND \$96 \$90 \$89 ch[13] VPWR \$I132 VGND sky130_fd_sc_hd__mux2_1
X$28 VGND \$54 \$48 \$47 ch[7] VPWR \$I131 VGND sky130_fd_sc_hd__mux2_1
X$29 VGND \$61 \$55 \$54 ch[8] VPWR \$I130 VGND sky130_fd_sc_hd__mux2_1
X$30 VGND \$89 \$83 \$82 ch[12] VPWR \$I129 VGND sky130_fd_sc_hd__mux2_1
X$31 VGND \$68 \$62 \$61 ch[9] VPWR \$I128 VGND sky130_fd_sc_hd__mux2_1
X$32 VGND \$75 \$69 \$68 ch[10] VPWR \$I127 VGND sky130_fd_sc_hd__mux2_1
X$33 VGND \$82 \$76 \$75 ch[11] VPWR \$I126 VGND sky130_fd_sc_hd__mux2_1
.ENDS arbchain

.SUBCKT sky130_fd_sc_hd__dlrtp_1 VGND RESET_B Q GATE D VPWR VPB sky130_gnd
M$1 \$6 D VPWR VPB sky130_fd_pr__pfet_01v8_hvt L=0.15 W=0.64 AS=0.1664
+ AD=0.0864 PS=1.8 PD=0.91
M$2 VPWR \$6 \$18 VPB sky130_fd_pr__pfet_01v8_hvt L=0.15 W=0.64 AS=0.0864
+ AD=0.0935 PS=0.91 PD=0.965
M$3 \$18 \$4 \$7 VPB sky130_fd_pr__pfet_01v8_hvt L=0.15 W=0.36 AS=0.0935
+ AD=0.0666 PS=0.965 PD=0.73
M$4 \$19 \$5 \$7 VPB sky130_fd_pr__pfet_01v8_hvt L=0.15 W=0.36 AS=0.0822
+ AD=0.0666 PS=0.835 PD=0.73
M$5 VPWR \$8 \$19 VPB sky130_fd_pr__pfet_01v8_hvt L=0.15 W=0.42 AS=0.2006
+ AD=0.0822 PS=1.61 PD=0.835
M$6 VPWR \$7 \$8 VPB sky130_fd_pr__pfet_01v8_hvt L=0.15 W=1 AS=0.2006 AD=0.165
+ PS=1.61 PD=1.33
M$7 \$8 RESET_B VPWR VPB sky130_fd_pr__pfet_01v8_hvt L=0.15 W=1 AS=0.165
+ AD=0.155 PS=1.33 PD=1.31
M$8 VPWR \$8 Q VPB sky130_fd_pr__pfet_01v8_hvt L=0.15 W=1 AS=0.155 AD=0.26
+ PS=1.31 PD=2.52
M$9 \$4 GATE VPWR VPB sky130_fd_pr__pfet_01v8_hvt L=0.15 W=0.64 AS=0.1664
+ AD=0.0864 PS=1.8 PD=0.91
M$10 VPWR \$4 \$5 VPB sky130_fd_pr__pfet_01v8_hvt L=0.15 W=0.64 AS=0.0864
+ AD=0.1664 PS=0.91 PD=1.8
M$11 \$8 \$7 \$15 sky130_gnd sky130_fd_pr__nfet_01v8 L=0.15 W=0.65 AS=0.169
+ AD=0.10725 PS=1.82 PD=0.98
M$12 \$15 RESET_B VGND sky130_gnd sky130_fd_pr__nfet_01v8 L=0.15 W=0.65
+ AS=0.10725 AD=0.10075 PS=0.98 PD=0.96
M$13 VGND \$8 Q sky130_gnd sky130_fd_pr__nfet_01v8 L=0.15 W=0.65 AS=0.10075
+ AD=0.169 PS=0.96 PD=1.82
M$14 \$6 D VGND sky130_gnd sky130_fd_pr__nfet_01v8 L=0.15 W=0.42 AS=0.1092
+ AD=0.0567 PS=1.36 PD=0.69
M$15 VGND \$6 \$11 sky130_gnd sky130_fd_pr__nfet_01v8 L=0.15 W=0.42 AS=0.0567
+ AD=0.07665 PS=0.69 PD=0.785
M$16 \$11 \$5 \$7 sky130_gnd sky130_fd_pr__nfet_01v8 L=0.15 W=0.42 AS=0.07665
+ AD=0.0588 PS=0.785 PD=0.7
M$17 \$7 \$4 \$12 sky130_gnd sky130_fd_pr__nfet_01v8 L=0.15 W=0.42 AS=0.0588
+ AD=0.05985 PS=0.7 PD=0.705
M$18 \$12 \$8 VGND sky130_gnd sky130_fd_pr__nfet_01v8 L=0.15 W=0.42 AS=0.05985
+ AD=0.1092 PS=0.705 PD=1.36
M$19 \$4 GATE VGND sky130_gnd sky130_fd_pr__nfet_01v8 L=0.15 W=0.42 AS=0.1092
+ AD=0.0567 PS=1.36 PD=0.69
M$20 VGND \$4 \$5 sky130_gnd sky130_fd_pr__nfet_01v8 L=0.15 W=0.42 AS=0.0567
+ AD=0.1092 PS=0.69 PD=1.36
.ENDS sky130_fd_sc_hd__dlrtp_1

.SUBCKT sky130_fd_sc_hd__mux2_1 VGND X A1 A0 S VPWR VPB sky130_gnd
M$1 VPWR S \$13 VPB sky130_fd_pr__pfet_01v8_hvt L=0.15 W=0.42 AS=0.15835
+ AD=0.07665 PS=1.395 PD=0.785
M$2 \$13 A0 \$5 VPB sky130_fd_pr__pfet_01v8_hvt L=0.15 W=0.42 AS=0.07665
+ AD=0.1932 PS=0.785 PD=1.34
M$3 \$5 A1 \$14 VPB sky130_fd_pr__pfet_01v8_hvt L=0.15 W=0.42 AS=0.1932
+ AD=0.0441 PS=1.34 PD=0.63
M$4 \$14 \$7 VPWR VPB sky130_fd_pr__pfet_01v8_hvt L=0.15 W=0.42 AS=0.0441
+ AD=0.0693 PS=0.63 PD=0.75
M$5 VPWR S \$7 VPB sky130_fd_pr__pfet_01v8_hvt L=0.15 W=0.42 AS=0.0693
+ AD=0.1176 PS=0.75 PD=1.4
M$6 X \$5 VPWR VPB sky130_fd_pr__pfet_01v8_hvt L=0.15 W=1 AS=0.26 AD=0.15835
+ PS=2.52 PD=1.395
M$7 VGND S \$8 sky130_gnd sky130_fd_pr__nfet_01v8 L=0.15 W=0.42 AS=0.11285
+ AD=0.0693 PS=1.045 PD=0.75
M$8 \$8 A1 \$5 sky130_gnd sky130_fd_pr__nfet_01v8 L=0.15 W=0.42 AS=0.0693
+ AD=0.09975 PS=0.75 PD=0.895
M$9 \$5 A0 \$9 sky130_gnd sky130_fd_pr__nfet_01v8 L=0.15 W=0.42 AS=0.09975
+ AD=0.0693 PS=0.895 PD=0.75
M$10 \$9 \$7 VGND sky130_gnd sky130_fd_pr__nfet_01v8 L=0.15 W=0.42 AS=0.0693
+ AD=0.1449 PS=0.75 PD=1.11
M$11 VGND S \$7 sky130_gnd sky130_fd_pr__nfet_01v8 L=0.15 W=0.42 AS=0.1449
+ AD=0.1092 PS=1.11 PD=1.36
M$12 X \$5 VGND sky130_gnd sky130_fd_pr__nfet_01v8 L=0.15 W=0.65 AS=0.169
+ AD=0.11285 PS=1.82 PD=1.045
.ENDS sky130_fd_sc_hd__mux2_1
