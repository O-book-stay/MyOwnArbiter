* Extracted by KLayout with SKY130 LVS runset on : 21/08/2026 16:17

.SUBCKT arbchain
X$1 \$1 \$59 \$57 \$1 \$1 \$1 sky130_gnd sky130_fd_sc_hd__dlrtp_1
X$2 \$1 \$1 \$1 \$1 \$1 sky130_gnd sky130_fd_sc_hd__mux2_1
X$3 \$1 \$1 \$1 \$1 \$1 sky130_gnd sky130_fd_sc_hd__mux2_1
X$4 \$1 \$1 \$1 \$1 \$1 sky130_gnd sky130_fd_sc_hd__mux2_1
X$5 \$1 \$1 \$1 \$1 \$1 sky130_gnd sky130_fd_sc_hd__mux2_1
X$6 \$1 \$1 \$1 \$1 \$1 sky130_gnd sky130_fd_sc_hd__mux2_1
X$7 \$1 \$1 \$1 \$1 \$1 sky130_gnd sky130_fd_sc_hd__mux2_1
X$8 \$1 \$1 \$1 \$1 \$1 sky130_gnd sky130_fd_sc_hd__mux2_1
X$9 \$1 \$1 \$1 \$1 \$1 sky130_gnd sky130_fd_sc_hd__mux2_1
X$10 \$1 \$1 \$1 \$1 \$1 sky130_gnd sky130_fd_sc_hd__mux2_1
X$11 \$1 \$1 \$1 \$1 \$1 sky130_gnd sky130_fd_sc_hd__mux2_1
X$12 \$1 \$1 \$1 \$1 \$1 sky130_gnd sky130_fd_sc_hd__mux2_1
X$13 \$1 \$1 \$1 \$1 \$1 sky130_gnd sky130_fd_sc_hd__mux2_1
X$14 \$1 \$1 \$1 \$1 \$1 sky130_gnd sky130_fd_sc_hd__mux2_1
X$15 \$1 \$1 \$1 \$1 \$1 sky130_gnd sky130_fd_sc_hd__mux2_1
X$16 \$1 \$1 \$1 \$1 \$1 sky130_gnd sky130_fd_sc_hd__mux2_1
X$17 \$1 \$1 \$1 \$1 \$1 sky130_gnd sky130_fd_sc_hd__mux2_1
X$18 \$1 \$1 \$1 \$1 \$1 sky130_gnd sky130_fd_sc_hd__mux2_1
X$19 \$1 \$1 \$1 \$1 \$1 sky130_gnd sky130_fd_sc_hd__mux2_1
X$20 \$1 \$1 \$1 \$1 \$1 sky130_gnd sky130_fd_sc_hd__mux2_1
X$21 \$1 \$1 \$1 \$1 \$1 sky130_gnd sky130_fd_sc_hd__mux2_1
X$22 \$1 \$1 \$1 \$1 \$1 sky130_gnd sky130_fd_sc_hd__mux2_1
X$23 \$1 \$1 \$1 \$1 \$1 sky130_gnd sky130_fd_sc_hd__mux2_1
X$24 \$1 \$1 \$1 \$1 \$1 sky130_gnd sky130_fd_sc_hd__mux2_1
X$25 \$1 \$1 \$1 \$1 \$1 sky130_gnd sky130_fd_sc_hd__mux2_1
X$26 \$1 \$1 \$1 \$8 \$8 sky130_gnd sky130_fd_sc_hd__mux2_1
X$27 \$1 \$1 \$1 \$56 \$56 sky130_gnd sky130_fd_sc_hd__mux2_1
X$28 \$1 \$1 \$1 \$15 \$15 sky130_gnd sky130_fd_sc_hd__mux2_1
X$29 \$1 \$1 \$1 \$22 \$22 sky130_gnd sky130_fd_sc_hd__mux2_1
X$30 \$1 \$1 \$1 \$50 \$50 sky130_gnd sky130_fd_sc_hd__mux2_1
X$31 \$1 \$1 \$1 \$29 \$29 sky130_gnd sky130_fd_sc_hd__mux2_1
X$32 \$1 \$1 \$1 \$36 \$36 sky130_gnd sky130_fd_sc_hd__mux2_1
X$33 \$1 \$1 \$1 \$43 \$43 sky130_gnd sky130_fd_sc_hd__mux2_1
.ENDS arbchain

.SUBCKT sky130_fd_sc_hd__dlrtp_1 VGND RESET_B Q GATE D VPWR sky130_gnd
M$1 \$6 D VPWR VPB sky130_fd_pr__pfet_01v8_hvt L=0.15 W=0.64 AS=0.1664
+ AD=0.0864 PS=1.8 PD=0.91
M$2 VPWR \$6 \$18 VPB sky130_fd_pr__pfet_01v8_hvt L=0.15 W=0.64 AS=0.0864
+ AD=0.0935 PS=0.91 PD=0.965
M$3 \$18 \$4 \$7 VPB sky130_fd_pr__pfet_01v8_hvt L=0.15 W=0.36 AS=0.0935
+ AD=0.0666 PS=0.965 PD=0.73
M$4 \$19 \$5 \$7 VPB sky130_fd_pr__pfet_01v8_hvt L=0.15 W=0.36 AS=0.0822
+ AD=0.0666 PS=0.835 PD=0.73
M$5 VPWR \$8 \$19 VPB sky130_fd_pr__pfet_01v8_hvt L=0.15 W=0.42 AS=0.2006
+ AD=0.0822 PS=1.61 PD=0.835
M$6 VPWR \$7 \$8 VPB sky130_fd_pr__pfet_01v8_hvt L=0.15 W=1 AS=0.2006 AD=0.165
+ PS=1.61 PD=1.33
M$7 \$8 RESET_B VPWR VPB sky130_fd_pr__pfet_01v8_hvt L=0.15 W=1 AS=0.165
+ AD=0.155 PS=1.33 PD=1.31
M$8 VPWR \$8 Q VPB sky130_fd_pr__pfet_01v8_hvt L=0.15 W=1 AS=0.155 AD=0.26
+ PS=1.31 PD=2.52
M$9 \$4 GATE VPWR VPB sky130_fd_pr__pfet_01v8_hvt L=0.15 W=0.64 AS=0.1664
+ AD=0.0864 PS=1.8 PD=0.91
M$10 VPWR \$4 \$5 VPB sky130_fd_pr__pfet_01v8_hvt L=0.15 W=0.64 AS=0.0864
+ AD=0.1664 PS=0.91 PD=1.8
M$11 \$8 \$7 \$15 sky130_gnd sky130_fd_pr__nfet_01v8 L=0.15 W=0.65 AS=0.169
+ AD=0.10725 PS=1.82 PD=0.98
M$12 \$15 RESET_B VGND sky130_gnd sky130_fd_pr__nfet_01v8 L=0.15 W=0.65
+ AS=0.10725 AD=0.10075 PS=0.98 PD=0.96
M$13 VGND \$8 Q sky130_gnd sky130_fd_pr__nfet_01v8 L=0.15 W=0.65 AS=0.10075
+ AD=0.169 PS=0.96 PD=1.82
M$14 \$6 D VGND sky130_gnd sky130_fd_pr__nfet_01v8 L=0.15 W=0.42 AS=0.1092
+ AD=0.0567 PS=1.36 PD=0.69
M$15 VGND \$6 \$11 sky130_gnd sky130_fd_pr__nfet_01v8 L=0.15 W=0.42 AS=0.0567
+ AD=0.07665 PS=0.69 PD=0.785
M$16 \$11 \$5 \$7 sky130_gnd sky130_fd_pr__nfet_01v8 L=0.15 W=0.42 AS=0.07665
+ AD=0.0588 PS=0.785 PD=0.7
M$17 \$7 \$4 \$12 sky130_gnd sky130_fd_pr__nfet_01v8 L=0.15 W=0.42 AS=0.0588
+ AD=0.05985 PS=0.7 PD=0.705
M$18 \$12 \$8 VGND sky130_gnd sky130_fd_pr__nfet_01v8 L=0.15 W=0.42 AS=0.05985
+ AD=0.1092 PS=0.705 PD=1.36
M$19 \$4 GATE VGND sky130_gnd sky130_fd_pr__nfet_01v8 L=0.15 W=0.42 AS=0.1092
+ AD=0.0567 PS=1.36 PD=0.69
M$20 VGND \$4 \$5 sky130_gnd sky130_fd_pr__nfet_01v8 L=0.15 W=0.42 AS=0.0567
+ AD=0.1092 PS=0.69 PD=1.36
.ENDS sky130_fd_sc_hd__dlrtp_1

.SUBCKT sky130_fd_sc_hd__mux2_1 X A1 A0 S VPWR sky130_gnd
M$1 VPWR S \$13 VPB sky130_fd_pr__pfet_01v8_hvt L=0.15 W=0.42 AS=0.15835
+ AD=0.07665 PS=1.395 PD=0.785
M$2 \$13 A0 \$9 VPB sky130_fd_pr__pfet_01v8_hvt L=0.15 W=0.42 AS=0.07665
+ AD=0.1932 PS=0.785 PD=1.34
M$3 \$9 A1 \$14 VPB sky130_fd_pr__pfet_01v8_hvt L=0.15 W=0.42 AS=0.1932
+ AD=0.0441 PS=1.34 PD=0.63
M$4 \$14 \$6 VPWR VPB sky130_fd_pr__pfet_01v8_hvt L=0.15 W=0.42 AS=0.0441
+ AD=0.0693 PS=0.63 PD=0.75
M$5 VPWR S \$6 VPB sky130_fd_pr__pfet_01v8_hvt L=0.15 W=0.42 AS=0.0693
+ AD=0.1176 PS=0.75 PD=1.4
M$6 X \$9 VPWR VPB sky130_fd_pr__pfet_01v8_hvt L=0.15 W=1 AS=0.26 AD=0.15835
+ PS=2.52 PD=1.395
M$7 VGND S \$7 sky130_gnd sky130_fd_pr__nfet_01v8 L=0.15 W=0.42 AS=0.11285
+ AD=0.0693 PS=1.045 PD=0.75
M$8 \$7 A1 \$9 sky130_gnd sky130_fd_pr__nfet_01v8 L=0.15 W=0.42 AS=0.0693
+ AD=0.09975 PS=0.75 PD=0.895
M$9 \$9 A0 \$8 sky130_gnd sky130_fd_pr__nfet_01v8 L=0.15 W=0.42 AS=0.09975
+ AD=0.0693 PS=0.895 PD=0.75
M$10 \$8 \$6 VGND sky130_gnd sky130_fd_pr__nfet_01v8 L=0.15 W=0.42 AS=0.0693
+ AD=0.1449 PS=0.75 PD=1.11
M$11 VGND S \$6 sky130_gnd sky130_fd_pr__nfet_01v8 L=0.15 W=0.42 AS=0.1449
+ AD=0.1092 PS=1.11 PD=1.36
M$12 X \$9 VGND sky130_gnd sky130_fd_pr__nfet_01v8 L=0.15 W=0.65 AS=0.169
+ AD=0.11285 PS=1.82 PD=1.045
.ENDS sky130_fd_sc_hd__mux2_1
