* Extracted by KLayout with SKY130 LVS runset on : 25/08/2026 23:15

.SUBCKT arbchain
X$1 \$2 \$5 EN EN
+ ch[0]|ch[10]|ch[11]|ch[12]|ch[13]|ch[14]|ch[15]|ch[1]|ch[2]|ch[3]|ch[4]|ch[5]|ch[6]|ch[7]|ch[8]|ch[9]
+ ch[0]|ch[10]|ch[11]|ch[12]|ch[13]|ch[14]|ch[15]|ch[1]|ch[2]|ch[3]|ch[4]|ch[5]|ch[6]|ch[7]|ch[8]|ch[9]
+ sky130_gnd sky130_fd_sc_hd__mux2_1
X$2 \$2 \$6 EN EN
+ ch[0]|ch[10]|ch[11]|ch[12]|ch[13]|ch[14]|ch[15]|ch[1]|ch[2]|ch[3]|ch[4]|ch[5]|ch[6]|ch[7]|ch[8]|ch[9]
+ ch[0]|ch[10]|ch[11]|ch[12]|ch[13]|ch[14]|ch[15]|ch[1]|ch[2]|ch[3]|ch[4]|ch[5]|ch[6]|ch[7]|ch[8]|ch[9]
+ sky130_gnd sky130_fd_sc_hd__mux2_1
X$3 \$2 \$67 \$69 \$68 \$65
+ ch[0]|ch[10]|ch[11]|ch[12]|ch[13]|ch[14]|ch[15]|ch[1]|ch[2]|ch[3]|ch[4]|ch[5]|ch[6]|ch[7]|ch[8]|ch[9]
+ sky130_gnd sky130_fd_sc_hd__dlrtp_1
X$4 \$2 \$10 \$4 \$6
+ ch[0]|ch[10]|ch[11]|ch[12]|ch[13]|ch[14]|ch[15]|ch[1]|ch[2]|ch[3]|ch[4]|ch[5]|ch[6]|ch[7]|ch[8]|ch[9]
+ ch[0]|ch[10]|ch[11]|ch[12]|ch[13]|ch[14]|ch[15]|ch[1]|ch[2]|ch[3]|ch[4]|ch[5]|ch[6]|ch[7]|ch[8]|ch[9]
+ sky130_gnd sky130_fd_sc_hd__mux2_1
X$5 \$2 \$14 \$9 \$11
+ ch[0]|ch[10]|ch[11]|ch[12]|ch[13]|ch[14]|ch[15]|ch[1]|ch[2]|ch[3]|ch[4]|ch[5]|ch[6]|ch[7]|ch[8]|ch[9]
+ ch[0]|ch[10]|ch[11]|ch[12]|ch[13]|ch[14]|ch[15]|ch[1]|ch[2]|ch[3]|ch[4]|ch[5]|ch[6]|ch[7]|ch[8]|ch[9]
+ sky130_gnd sky130_fd_sc_hd__mux2_1
X$6 \$2 \$18 \$13 \$14
+ ch[0]|ch[10]|ch[11]|ch[12]|ch[13]|ch[14]|ch[15]|ch[1]|ch[2]|ch[3]|ch[4]|ch[5]|ch[6]|ch[7]|ch[8]|ch[9]
+ ch[0]|ch[10]|ch[11]|ch[12]|ch[13]|ch[14]|ch[15]|ch[1]|ch[2]|ch[3]|ch[4]|ch[5]|ch[6]|ch[7]|ch[8]|ch[9]
+ sky130_gnd sky130_fd_sc_hd__mux2_1
X$7 \$2 \$23 \$17 \$19
+ ch[0]|ch[10]|ch[11]|ch[12]|ch[13]|ch[14]|ch[15]|ch[1]|ch[2]|ch[3]|ch[4]|ch[5]|ch[6]|ch[7]|ch[8]|ch[9]
+ ch[0]|ch[10]|ch[11]|ch[12]|ch[13]|ch[14]|ch[15]|ch[1]|ch[2]|ch[3]|ch[4]|ch[5]|ch[6]|ch[7]|ch[8]|ch[9]
+ sky130_gnd sky130_fd_sc_hd__mux2_1
X$8 \$2 \$25 \$21 \$23
+ ch[0]|ch[10]|ch[11]|ch[12]|ch[13]|ch[14]|ch[15]|ch[1]|ch[2]|ch[3]|ch[4]|ch[5]|ch[6]|ch[7]|ch[8]|ch[9]
+ ch[0]|ch[10]|ch[11]|ch[12]|ch[13]|ch[14]|ch[15]|ch[1]|ch[2]|ch[3]|ch[4]|ch[5]|ch[6]|ch[7]|ch[8]|ch[9]
+ sky130_gnd sky130_fd_sc_hd__mux2_1
X$9 \$2 \$30 \$26 \$27
+ ch[0]|ch[10]|ch[11]|ch[12]|ch[13]|ch[14]|ch[15]|ch[1]|ch[2]|ch[3]|ch[4]|ch[5]|ch[6]|ch[7]|ch[8]|ch[9]
+ ch[0]|ch[10]|ch[11]|ch[12]|ch[13]|ch[14]|ch[15]|ch[1]|ch[2]|ch[3]|ch[4]|ch[5]|ch[6]|ch[7]|ch[8]|ch[9]
+ sky130_gnd sky130_fd_sc_hd__mux2_1
X$10 \$2 \$34 \$29 \$30
+ ch[0]|ch[10]|ch[11]|ch[12]|ch[13]|ch[14]|ch[15]|ch[1]|ch[2]|ch[3]|ch[4]|ch[5]|ch[6]|ch[7]|ch[8]|ch[9]
+ ch[0]|ch[10]|ch[11]|ch[12]|ch[13]|ch[14]|ch[15]|ch[1]|ch[2]|ch[3]|ch[4]|ch[5]|ch[6]|ch[7]|ch[8]|ch[9]
+ sky130_gnd sky130_fd_sc_hd__mux2_1
X$11 \$2 \$38 \$33 \$35
+ ch[0]|ch[10]|ch[11]|ch[12]|ch[13]|ch[14]|ch[15]|ch[1]|ch[2]|ch[3]|ch[4]|ch[5]|ch[6]|ch[7]|ch[8]|ch[9]
+ ch[0]|ch[10]|ch[11]|ch[12]|ch[13]|ch[14]|ch[15]|ch[1]|ch[2]|ch[3]|ch[4]|ch[5]|ch[6]|ch[7]|ch[8]|ch[9]
+ sky130_gnd sky130_fd_sc_hd__mux2_1
X$12 \$2 \$42 \$37 \$38
+ ch[0]|ch[10]|ch[11]|ch[12]|ch[13]|ch[14]|ch[15]|ch[1]|ch[2]|ch[3]|ch[4]|ch[5]|ch[6]|ch[7]|ch[8]|ch[9]
+ ch[0]|ch[10]|ch[11]|ch[12]|ch[13]|ch[14]|ch[15]|ch[1]|ch[2]|ch[3]|ch[4]|ch[5]|ch[6]|ch[7]|ch[8]|ch[9]
+ sky130_gnd sky130_fd_sc_hd__mux2_1
X$13 \$2 \$46 \$41 \$43
+ ch[0]|ch[10]|ch[11]|ch[12]|ch[13]|ch[14]|ch[15]|ch[1]|ch[2]|ch[3]|ch[4]|ch[5]|ch[6]|ch[7]|ch[8]|ch[9]
+ ch[0]|ch[10]|ch[11]|ch[12]|ch[13]|ch[14]|ch[15]|ch[1]|ch[2]|ch[3]|ch[4]|ch[5]|ch[6]|ch[7]|ch[8]|ch[9]
+ sky130_gnd sky130_fd_sc_hd__mux2_1
X$14 \$2 \$50 \$45 \$46
+ ch[0]|ch[10]|ch[11]|ch[12]|ch[13]|ch[14]|ch[15]|ch[1]|ch[2]|ch[3]|ch[4]|ch[5]|ch[6]|ch[7]|ch[8]|ch[9]
+ ch[0]|ch[10]|ch[11]|ch[12]|ch[13]|ch[14]|ch[15]|ch[1]|ch[2]|ch[3]|ch[4]|ch[5]|ch[6]|ch[7]|ch[8]|ch[9]
+ sky130_gnd sky130_fd_sc_hd__mux2_1
X$15 \$2 \$65 \$61 \$63
+ ch[0]|ch[10]|ch[11]|ch[12]|ch[13]|ch[14]|ch[15]|ch[1]|ch[2]|ch[3]|ch[4]|ch[5]|ch[6]|ch[7]|ch[8]|ch[9]
+ ch[0]|ch[10]|ch[11]|ch[12]|ch[13]|ch[14]|ch[15]|ch[1]|ch[2]|ch[3]|ch[4]|ch[5]|ch[6]|ch[7]|ch[8]|ch[9]
+ sky130_gnd sky130_fd_sc_hd__mux2_1
X$16 \$2 \$55 \$49 \$51
+ ch[0]|ch[10]|ch[11]|ch[12]|ch[13]|ch[14]|ch[15]|ch[1]|ch[2]|ch[3]|ch[4]|ch[5]|ch[6]|ch[7]|ch[8]|ch[9]
+ ch[0]|ch[10]|ch[11]|ch[12]|ch[13]|ch[14]|ch[15]|ch[1]|ch[2]|ch[3]|ch[4]|ch[5]|ch[6]|ch[7]|ch[8]|ch[9]
+ sky130_gnd sky130_fd_sc_hd__mux2_1
X$17 \$2 \$63 \$57 \$59
+ ch[0]|ch[10]|ch[11]|ch[12]|ch[13]|ch[14]|ch[15]|ch[1]|ch[2]|ch[3]|ch[4]|ch[5]|ch[6]|ch[7]|ch[8]|ch[9]
+ ch[0]|ch[10]|ch[11]|ch[12]|ch[13]|ch[14]|ch[15]|ch[1]|ch[2]|ch[3]|ch[4]|ch[5]|ch[6]|ch[7]|ch[8]|ch[9]
+ sky130_gnd sky130_fd_sc_hd__mux2_1
X$18 \$2 \$58 \$53 \$55
+ ch[0]|ch[10]|ch[11]|ch[12]|ch[13]|ch[14]|ch[15]|ch[1]|ch[2]|ch[3]|ch[4]|ch[5]|ch[6]|ch[7]|ch[8]|ch[9]
+ ch[0]|ch[10]|ch[11]|ch[12]|ch[13]|ch[14]|ch[15]|ch[1]|ch[2]|ch[3]|ch[4]|ch[5]|ch[6]|ch[7]|ch[8]|ch[9]
+ sky130_gnd sky130_fd_sc_hd__mux2_1
X$19 \$2 \$9 \$6 \$4
+ ch[0]|ch[10]|ch[11]|ch[12]|ch[13]|ch[14]|ch[15]|ch[1]|ch[2]|ch[3]|ch[4]|ch[5]|ch[6]|ch[7]|ch[8]|ch[9]
+ ch[0]|ch[10]|ch[11]|ch[12]|ch[13]|ch[14]|ch[15]|ch[1]|ch[2]|ch[3]|ch[4]|ch[5]|ch[6]|ch[7]|ch[8]|ch[9]
+ sky130_gnd sky130_fd_sc_hd__mux2_1
X$20 \$2 \$15 \$11 \$9
+ ch[0]|ch[10]|ch[11]|ch[12]|ch[13]|ch[14]|ch[15]|ch[1]|ch[2]|ch[3]|ch[4]|ch[5]|ch[6]|ch[7]|ch[8]|ch[9]
+ ch[0]|ch[10]|ch[11]|ch[12]|ch[13]|ch[14]|ch[15]|ch[1]|ch[2]|ch[3]|ch[4]|ch[5]|ch[6]|ch[7]|ch[8]|ch[9]
+ sky130_gnd sky130_fd_sc_hd__mux2_1
X$21 \$2 \$66 \$63 \$61
+ ch[0]|ch[10]|ch[11]|ch[12]|ch[13]|ch[14]|ch[15]|ch[1]|ch[2]|ch[3]|ch[4]|ch[5]|ch[6]|ch[7]|ch[8]|ch[9]
+ ch[0]|ch[10]|ch[11]|ch[12]|ch[13]|ch[14]|ch[15]|ch[1]|ch[2]|ch[3]|ch[4]|ch[5]|ch[6]|ch[7]|ch[8]|ch[9]
+ sky130_gnd sky130_fd_sc_hd__mux2_1
X$22 \$2 \$17 \$14 \$13
+ ch[0]|ch[10]|ch[11]|ch[12]|ch[13]|ch[14]|ch[15]|ch[1]|ch[2]|ch[3]|ch[4]|ch[5]|ch[6]|ch[7]|ch[8]|ch[9]
+ ch[0]|ch[10]|ch[11]|ch[12]|ch[13]|ch[14]|ch[15]|ch[1]|ch[2]|ch[3]|ch[4]|ch[5]|ch[6]|ch[7]|ch[8]|ch[9]
+ sky130_gnd sky130_fd_sc_hd__mux2_1
X$23 \$2 \$22 \$19 \$17
+ ch[0]|ch[10]|ch[11]|ch[12]|ch[13]|ch[14]|ch[15]|ch[1]|ch[2]|ch[3]|ch[4]|ch[5]|ch[6]|ch[7]|ch[8]|ch[9]
+ ch[0]|ch[10]|ch[11]|ch[12]|ch[13]|ch[14]|ch[15]|ch[1]|ch[2]|ch[3]|ch[4]|ch[5]|ch[6]|ch[7]|ch[8]|ch[9]
+ sky130_gnd sky130_fd_sc_hd__mux2_1
X$24 \$2 \$62 \$59 \$57
+ ch[0]|ch[10]|ch[11]|ch[12]|ch[13]|ch[14]|ch[15]|ch[1]|ch[2]|ch[3]|ch[4]|ch[5]|ch[6]|ch[7]|ch[8]|ch[9]
+ ch[0]|ch[10]|ch[11]|ch[12]|ch[13]|ch[14]|ch[15]|ch[1]|ch[2]|ch[3]|ch[4]|ch[5]|ch[6]|ch[7]|ch[8]|ch[9]
+ sky130_gnd sky130_fd_sc_hd__mux2_1
X$25 \$2 \$26 \$23 \$21
+ ch[0]|ch[10]|ch[11]|ch[12]|ch[13]|ch[14]|ch[15]|ch[1]|ch[2]|ch[3]|ch[4]|ch[5]|ch[6]|ch[7]|ch[8]|ch[9]
+ ch[0]|ch[10]|ch[11]|ch[12]|ch[13]|ch[14]|ch[15]|ch[1]|ch[2]|ch[3]|ch[4]|ch[5]|ch[6]|ch[7]|ch[8]|ch[9]
+ sky130_gnd sky130_fd_sc_hd__mux2_1
X$26 \$2 \$31 \$27 \$26
+ ch[0]|ch[10]|ch[11]|ch[12]|ch[13]|ch[14]|ch[15]|ch[1]|ch[2]|ch[3]|ch[4]|ch[5]|ch[6]|ch[7]|ch[8]|ch[9]
+ ch[0]|ch[10]|ch[11]|ch[12]|ch[13]|ch[14]|ch[15]|ch[1]|ch[2]|ch[3]|ch[4]|ch[5]|ch[6]|ch[7]|ch[8]|ch[9]
+ sky130_gnd sky130_fd_sc_hd__mux2_1
X$27 \$2 \$57 \$55 \$53
+ ch[0]|ch[10]|ch[11]|ch[12]|ch[13]|ch[14]|ch[15]|ch[1]|ch[2]|ch[3]|ch[4]|ch[5]|ch[6]|ch[7]|ch[8]|ch[9]
+ ch[0]|ch[10]|ch[11]|ch[12]|ch[13]|ch[14]|ch[15]|ch[1]|ch[2]|ch[3]|ch[4]|ch[5]|ch[6]|ch[7]|ch[8]|ch[9]
+ sky130_gnd sky130_fd_sc_hd__mux2_1
X$28 \$2 \$33 \$30 \$29
+ ch[0]|ch[10]|ch[11]|ch[12]|ch[13]|ch[14]|ch[15]|ch[1]|ch[2]|ch[3]|ch[4]|ch[5]|ch[6]|ch[7]|ch[8]|ch[9]
+ ch[0]|ch[10]|ch[11]|ch[12]|ch[13]|ch[14]|ch[15]|ch[1]|ch[2]|ch[3]|ch[4]|ch[5]|ch[6]|ch[7]|ch[8]|ch[9]
+ sky130_gnd sky130_fd_sc_hd__mux2_1
X$29 \$2 \$39 \$35 \$33
+ ch[0]|ch[10]|ch[11]|ch[12]|ch[13]|ch[14]|ch[15]|ch[1]|ch[2]|ch[3]|ch[4]|ch[5]|ch[6]|ch[7]|ch[8]|ch[9]
+ ch[0]|ch[10]|ch[11]|ch[12]|ch[13]|ch[14]|ch[15]|ch[1]|ch[2]|ch[3]|ch[4]|ch[5]|ch[6]|ch[7]|ch[8]|ch[9]
+ sky130_gnd sky130_fd_sc_hd__mux2_1
X$30 \$2 \$54 \$51 \$49
+ ch[0]|ch[10]|ch[11]|ch[12]|ch[13]|ch[14]|ch[15]|ch[1]|ch[2]|ch[3]|ch[4]|ch[5]|ch[6]|ch[7]|ch[8]|ch[9]
+ ch[0]|ch[10]|ch[11]|ch[12]|ch[13]|ch[14]|ch[15]|ch[1]|ch[2]|ch[3]|ch[4]|ch[5]|ch[6]|ch[7]|ch[8]|ch[9]
+ sky130_gnd sky130_fd_sc_hd__mux2_1
X$31 \$2 \$41 \$38 \$37
+ ch[0]|ch[10]|ch[11]|ch[12]|ch[13]|ch[14]|ch[15]|ch[1]|ch[2]|ch[3]|ch[4]|ch[5]|ch[6]|ch[7]|ch[8]|ch[9]
+ ch[0]|ch[10]|ch[11]|ch[12]|ch[13]|ch[14]|ch[15]|ch[1]|ch[2]|ch[3]|ch[4]|ch[5]|ch[6]|ch[7]|ch[8]|ch[9]
+ sky130_gnd sky130_fd_sc_hd__mux2_1
X$32 \$2 \$47 \$43 \$41
+ ch[0]|ch[10]|ch[11]|ch[12]|ch[13]|ch[14]|ch[15]|ch[1]|ch[2]|ch[3]|ch[4]|ch[5]|ch[6]|ch[7]|ch[8]|ch[9]
+ ch[0]|ch[10]|ch[11]|ch[12]|ch[13]|ch[14]|ch[15]|ch[1]|ch[2]|ch[3]|ch[4]|ch[5]|ch[6]|ch[7]|ch[8]|ch[9]
+ sky130_gnd sky130_fd_sc_hd__mux2_1
X$33 \$2 \$49 \$46 \$45
+ ch[0]|ch[10]|ch[11]|ch[12]|ch[13]|ch[14]|ch[15]|ch[1]|ch[2]|ch[3]|ch[4]|ch[5]|ch[6]|ch[7]|ch[8]|ch[9]
+ ch[0]|ch[10]|ch[11]|ch[12]|ch[13]|ch[14]|ch[15]|ch[1]|ch[2]|ch[3]|ch[4]|ch[5]|ch[6]|ch[7]|ch[8]|ch[9]
+ sky130_gnd sky130_fd_sc_hd__mux2_1
.ENDS arbchain

.SUBCKT sky130_fd_sc_hd__dlrtp_1 VGND RESET_B Q GATE D VPWR sky130_gnd
M$1 \$6 D VPWR VPB sky130_fd_pr__pfet_01v8_hvt L=0.15 W=0.64 AS=0.1664
+ AD=0.0864 PS=1.8 PD=0.91
M$2 VPWR \$6 \$18 VPB sky130_fd_pr__pfet_01v8_hvt L=0.15 W=0.64 AS=0.0864
+ AD=0.0935 PS=0.91 PD=0.965
M$3 \$18 \$4 \$7 VPB sky130_fd_pr__pfet_01v8_hvt L=0.15 W=0.36 AS=0.0935
+ AD=0.0666 PS=0.965 PD=0.73
M$4 \$19 \$5 \$7 VPB sky130_fd_pr__pfet_01v8_hvt L=0.15 W=0.36 AS=0.0822
+ AD=0.0666 PS=0.835 PD=0.73
M$5 VPWR \$8 \$19 VPB sky130_fd_pr__pfet_01v8_hvt L=0.15 W=0.42 AS=0.2006
+ AD=0.0822 PS=1.61 PD=0.835
M$6 VPWR \$7 \$8 VPB sky130_fd_pr__pfet_01v8_hvt L=0.15 W=1 AS=0.2006 AD=0.165
+ PS=1.61 PD=1.33
M$7 \$8 RESET_B VPWR VPB sky130_fd_pr__pfet_01v8_hvt L=0.15 W=1 AS=0.165
+ AD=0.155 PS=1.33 PD=1.31
M$8 VPWR \$8 Q VPB sky130_fd_pr__pfet_01v8_hvt L=0.15 W=1 AS=0.155 AD=0.26
+ PS=1.31 PD=2.52
M$9 \$4 GATE VPWR VPB sky130_fd_pr__pfet_01v8_hvt L=0.15 W=0.64 AS=0.1664
+ AD=0.0864 PS=1.8 PD=0.91
M$10 VPWR \$4 \$5 VPB sky130_fd_pr__pfet_01v8_hvt L=0.15 W=0.64 AS=0.0864
+ AD=0.1664 PS=0.91 PD=1.8
M$11 \$8 \$7 \$15 sky130_gnd sky130_fd_pr__nfet_01v8 L=0.15 W=0.65 AS=0.169
+ AD=0.10725 PS=1.82 PD=0.98
M$12 \$15 RESET_B VGND sky130_gnd sky130_fd_pr__nfet_01v8 L=0.15 W=0.65
+ AS=0.10725 AD=0.10075 PS=0.98 PD=0.96
M$13 VGND \$8 Q sky130_gnd sky130_fd_pr__nfet_01v8 L=0.15 W=0.65 AS=0.10075
+ AD=0.169 PS=0.96 PD=1.82
M$14 \$6 D VGND sky130_gnd sky130_fd_pr__nfet_01v8 L=0.15 W=0.42 AS=0.1092
+ AD=0.0567 PS=1.36 PD=0.69
M$15 VGND \$6 \$11 sky130_gnd sky130_fd_pr__nfet_01v8 L=0.15 W=0.42 AS=0.0567
+ AD=0.07665 PS=0.69 PD=0.785
M$16 \$11 \$5 \$7 sky130_gnd sky130_fd_pr__nfet_01v8 L=0.15 W=0.42 AS=0.07665
+ AD=0.0588 PS=0.785 PD=0.7
M$17 \$7 \$4 \$12 sky130_gnd sky130_fd_pr__nfet_01v8 L=0.15 W=0.42 AS=0.0588
+ AD=0.05985 PS=0.7 PD=0.705
M$18 \$12 \$8 VGND sky130_gnd sky130_fd_pr__nfet_01v8 L=0.15 W=0.42 AS=0.05985
+ AD=0.1092 PS=0.705 PD=1.36
M$19 \$4 GATE VGND sky130_gnd sky130_fd_pr__nfet_01v8 L=0.15 W=0.42 AS=0.1092
+ AD=0.0567 PS=1.36 PD=0.69
M$20 VGND \$4 \$5 sky130_gnd sky130_fd_pr__nfet_01v8 L=0.15 W=0.42 AS=0.0567
+ AD=0.1092 PS=0.69 PD=1.36
.ENDS sky130_fd_sc_hd__dlrtp_1

.SUBCKT sky130_fd_sc_hd__mux2_1 VGND X A1 A0 S VPWR sky130_gnd
M$1 VPWR S \$13 VPB sky130_fd_pr__pfet_01v8_hvt L=0.15 W=0.42 AS=0.15835
+ AD=0.07665 PS=1.395 PD=0.785
M$2 \$13 A0 \$5 VPB sky130_fd_pr__pfet_01v8_hvt L=0.15 W=0.42 AS=0.07665
+ AD=0.1932 PS=0.785 PD=1.34
M$3 \$5 A1 \$14 VPB sky130_fd_pr__pfet_01v8_hvt L=0.15 W=0.42 AS=0.1932
+ AD=0.0441 PS=1.34 PD=0.63
M$4 \$14 \$7 VPWR VPB sky130_fd_pr__pfet_01v8_hvt L=0.15 W=0.42 AS=0.0441
+ AD=0.0693 PS=0.63 PD=0.75
M$5 VPWR S \$7 VPB sky130_fd_pr__pfet_01v8_hvt L=0.15 W=0.42 AS=0.0693
+ AD=0.1176 PS=0.75 PD=1.4
M$6 X \$5 VPWR VPB sky130_fd_pr__pfet_01v8_hvt L=0.15 W=1 AS=0.26 AD=0.15835
+ PS=2.52 PD=1.395
M$7 VGND S \$8 sky130_gnd sky130_fd_pr__nfet_01v8 L=0.15 W=0.42 AS=0.11285
+ AD=0.0693 PS=1.045 PD=0.75
M$8 \$8 A1 \$5 sky130_gnd sky130_fd_pr__nfet_01v8 L=0.15 W=0.42 AS=0.0693
+ AD=0.09975 PS=0.75 PD=0.895
M$9 \$5 A0 \$9 sky130_gnd sky130_fd_pr__nfet_01v8 L=0.15 W=0.42 AS=0.09975
+ AD=0.0693 PS=0.895 PD=0.75
M$10 \$9 \$7 VGND sky130_gnd sky130_fd_pr__nfet_01v8 L=0.15 W=0.42 AS=0.0693
+ AD=0.1449 PS=0.75 PD=1.11
M$11 VGND S \$7 sky130_gnd sky130_fd_pr__nfet_01v8 L=0.15 W=0.42 AS=0.1449
+ AD=0.1092 PS=1.11 PD=1.36
M$12 X \$5 VGND sky130_gnd sky130_fd_pr__nfet_01v8 L=0.15 W=0.65 AS=0.169
+ AD=0.11285 PS=1.82 PD=1.045
.ENDS sky130_fd_sc_hd__mux2_1
